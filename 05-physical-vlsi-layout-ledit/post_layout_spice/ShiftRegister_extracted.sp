* ==============================================================================
* File: CA5/ShiftRegister_extracted.sp
* Project: Digital Integrated Circuits & VLSI Design
* Course: Digital Electronics (Fall 2023)
* Author: Alireza Najafi Motiei (Student ID: 810100224)
* Instructor: Dr. Shaghayegh Vahdat
* Department: Faculty of Electrical and Computer Engineering, University of Tehran
* ==============================================================================

* SPICE netlist written by S-Edit Win32 6.00
* Written on Jan 17, 2025 at 14:45:52

* Waveform probing commands
.probe
.options probefilename="D:\digitalElectronics_CA\CA5\PART2\HSPICE\shift register.dat"
+ probesdbfile="D:\digitalElectronics_CA\CA5\PART2\S-EDIT\Shift_register.sdb"
+ probetopmodule="shift_register"

* No Ports in cell: PageID_Tanner
* End of module with no ports: PageID_Tanner

.SUBCKT NAND3 A B C Out Gnd Vdd
M4 Out C 1 Gnd NMOS W='28*l' L='2*l' AS='148*l*l' AD='84*l*l' PS='68*l' PD='34*l' M=1
M5 1 B 2 Gnd NMOS W='28*l' L='2*l' AS='84*l*l' AD='84*l*l' PS='34*l' PD='34*l' M=1
M6 2 A Gnd Gnd NMOS W='28*l' L='2*l' AS='84*l*l' AD='144*l*l' PS='34*l' PD='68*l' M=1
* Page Size:  5x7
* S-Edit  3-Input NAND Gate (TIB)
* Designed by: J. Luo   Jan 17, 2025  14:39:31
* Schematic generated by S-Edit
* from file D:\digitalElectronics_CA\CA5\PART2\S-EDIT\Shift_register / module NAND3 / page Page0
M1 Out A Vdd Vdd PMOS W='28*l' L='2*l' AS='84*l*l' AD='144*l*l' PS='34*l' PD='68*l' M=1
M2 Out B Vdd Vdd PMOS W='28*l' L='2*l' AS='84*l*l' AD='84*l*l' PS='34*l' PD='34*l' M=1
M3 Out C Vdd Vdd PMOS W='28*l' L='2*l' AS='148*l*l' AD='84*l*l' PS='68*l' PD='34*l' M=1
.ENDS

.SUBCKT NAND2 A B Out Gnd Vdd
M3 Out B 1 Gnd NMOS W='28*l' L='2*l' AS='148*l*l' AD='84*l*l' PS='68*l' PD='34*l' M=1
M4 1 A Gnd Gnd NMOS W='28*l' L='2*l' AS='84*l*l' AD='144*l*l' PS='34*l' PD='68*l' M=1
* Page Size:  5x7
* S-Edit  2-Input NAND Gate (TIB)
* Designed by: J. Luo  Jan 17, 2025  14:39:31
* Schematic generated by S-Edit
* from file D:\digitalElectronics_CA\CA5\PART2\S-EDIT\Shift_register / module NAND2 / page Page0
M2 Out B Vdd Vdd PMOS W='28*l' L='2*l' AS='144*l*l' AD='84*l*l' PS='68*l' PD='34*l' M=1
M1 Out A Vdd Vdd PMOS W='28*l' L='2*l' AS='84*l*l' AD='144*l*l' PS='34*l' PD='68*l' M=1
.ENDS

.SUBCKT DFF Clock Data Q Q_bar Gnd Vdd
XNAND2_1 N7 N13 N10 Gnd Vdd NAND2
XNAND2_2 N10 Clock N13 Gnd Vdd NAND2
XNAND2_3 N13 Q_bar Q Gnd Vdd NAND2
XNAND2_4 Q N1 Q_bar Gnd Vdd NAND2
XNAND2_6 N1 Data N7 Gnd Vdd NAND2
XNAND3_1 N13 Clock N7 N1 Gnd Vdd NAND3
.ENDS

.SUBCKT Pad_Bond SIGNAL Subs
C1 SIGNAL Subs 0.25pF
* Page Size:  5x7
* S-Edit  Output Pad
* Designed by: D.Gunawan, J.Luo, K.Schaefer  Jan 17, 2025  14:40:55
* Schematic generated by S-Edit
* from file D:\digitalElectronics_CA\CA5\PART2\S-EDIT\Shift_register / module Pad_Bond / page Page0
.ENDS

.SUBCKT PadBidirHE_2.0u DataIn DataInB DataInUnBuf DataOut OE Pad Gnd Subs Vdd
MN_4_1 OEB OE Gnd Gnd NMOS W=22u L=2u AS=66p AD=66p PS=24u PD=24u M=1
MN_4_2 N29 DataOut Gnd Gnd NMOS W=22u L=2u AS=66p AD=66p PS=24u PD=24u M=1
MN_4_3 N20 OE N29 Gnd NMOS W=22u L=2u AS=66p AD=66p PS=24u PD=24u M=1
MN_4_4 N29 OEB Gnd Gnd NMOS W=22u L=2u AS=66p AD=66p PS=24u PD=24u M=1
MN_4_5 Pad N29 Gnd Gnd NMOS W=22u L=2u AS=66p AD=66p PS=24u PD=24u M=10
MN_4_6 DataInB DataInUnBuf Gnd Gnd NMOS W=22u L=2u AS=66p AD=66p PS=24u PD=24u M=2
MN_4_7 DataIn DataInB Gnd Gnd NMOS W=22u L=2u AS=66p AD=66p PS=24u PD=24u M=4
XPad_Bond_1 Pad Subs Pad_Bond
* Page Size:  5x7
* S-Edit  Bidirectional Pad
* Designed by: D.Gunawan, J.Luo  Jan 17, 2025  14:40:55
* Schematic generated by S-Edit
* from file D:\digitalElectronics_CA\CA5\PART2\S-EDIT\Shift_register / module PadBidirHE_2.0u / page Page0
MP_4_1 OEB OE Vdd Vdd PMOS W=22u L=2u AS=66p AD=66p PS=24u PD=24u M=1
MP_4_2 N20 DataOut Vdd Vdd PMOS W=22u L=2u AS=66p AD=66p PS=24u PD=24u M=2
MP_4_3 N29 OEB N20 Vdd PMOS W=22u L=2u AS=66p AD=66p PS=24u PD=24u M=2
MP_4_4 N20 OE Vdd Vdd PMOS W=22u L=2u AS=66p AD=66p PS=24u PD=24u M=1
MP_4_5 Pad N20 Vdd Vdd PMOS W=22u L=2u AS=66p AD=66p PS=24u PD=24u M=10
MP_4_6 DataInB DataInUnBuf Vdd Vdd PMOS W=22u L=2u AS=66p AD=66p PS=24u PD=24u M=2
MP_4_7 DataIn DataInB Vdd Vdd PMOS W=22u L=2u AS=66p AD=66p PS=24u PD=24u M=4
R1 Pad DataInUnBuf 100 TC1=0.0 TC2=0.0
.ENDS

.SUBCKT PadBidirHE DataIn DataInB DataInUnBuf DataOut OE Pad Gnd Subs Vdd
XPadBidirHE_2.0u_1 DataIn DataInB DataInUnBuf DataOut OE Pad Gnd Subs Vdd
+ PadBidirHE_2.0u
* Page Size:  5x7
* S-Edit  Bidirectional Pad
* Designed by: D.Gunawan, J.Luo  Jan 17, 2025  14:40:55
* Schematic generated by S-Edit
* from file D:\digitalElectronics_CA\CA5\PART2\S-EDIT\Shift_register / module PadBidirHE / page Page0
.ENDS

.SUBCKT PadInC DataIn DataInB DataInUnBuf Pad Gnd Subs Vdd
XPadBidirHE_1 DataIn DataInB DataInUnBuf Gnd Gnd Pad Gnd Subs Vdd PadBidirHE
* Page Size:  5x7
* S-Edit  Input Pad
* Designed by: D.Gunawan, J.Luo  Jan 17, 2025  14:40:04
* Schematic generated by S-Edit
* from file D:\digitalElectronics_CA\CA5\PART2\S-EDIT\Shift_register / module PadInC / page Page0
.ENDS

.SUBCKT PadOut DataOut Pad Gnd Subs Vdd
XPadBidirHE_1 N6 N5 N4 DataOut Vdd Pad Gnd Subs Vdd PadBidirHE
* Page Size:  5x7
* S-Edit  Output Pad
* Designed by: D.Gunawan, J.Luo  Jan 17, 2025  14:40:55
* Schematic generated by S-Edit
* from file D:\digitalElectronics_CA\CA5\PART2\S-EDIT\Shift_register / module PadOut / page Page0
.ENDS

* Main circuit: shift_register
XDFF_1 N2 N4 N5 N7 Gnd Vdd DFF
XDFF_2 N2 N5 N6 N8 Gnd Vdd DFF
XDFF_3 N2 N6 N1 N9 Gnd Vdd DFF
XDFF_4 N2 N3 N4 N10 Gnd Vdd DFF
XPadInC_1 N2 N12 N11 Clock Gnd Subs Vdd PadInC
XPadInC_2 N3 N15 N14 Serial_Input Gnd Subs Vdd PadInC
XPadOut_1 N1 Serial_Output Gnd Subs Vdd PadOut
* End of main circuit: shift_register
